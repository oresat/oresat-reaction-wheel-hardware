* rev8 bus AC, asbuilt, caps at 8.4 V: 1 A drawn from leg C VIN, returned to PGND
.include /home/solomon/code/oresat/oresat-rw-board-rev8/.claude/worktrees/bus-ring-sim/sims/bus-ring/xyce/board_asbuilt.sub
.include /home/solomon/code/oresat/oresat-rw-board-rev8/.claude/worktrees/bus-ring-sim/sims/bus-ring/murata_dl/GRT155C81C225KE13_DC8.4V_25degC.mod
.include /home/solomon/code/oresat/oresat-rw-board-rev8/.claude/worktrees/bus-ring-sim/sims/bus-ring/murata_dl/GRT188C81C106ME13_DC8.4V_25degC.mod
.include /home/solomon/code/oresat/oresat-rw-board-rev8/.claude/worktrees/bus-ring-sim/sims/bus-ring/murata_dl/GRT32EC81C476KE13_DC8.4V_25degC.mod
XBRD devA_V devA_G devB_V devB_G devC_V 0 A_bot_V A_bot_G A_top_V A_top_G B_bot_V B_bot_G B_top_V B_top_G C_bot_V C_bot_G C_top_V C_top_G BULK_L_V BULK_L_G BULK_R_V BULK_R_G P105_V P105_G P110_V P110_G FEED_V FEED_G BOARD_ASBUILT
XC_A_bot_2u2_0402_0 A_bot_V A_bot_G GRT155C81C225KE13_DC8V4_25degC
XC_A_bot_2u2_0402_1 A_bot_V A_bot_G GRT155C81C225KE13_DC8V4_25degC
XC_A_bot_2u2_0402_2 A_bot_V A_bot_G GRT155C81C225KE13_DC8V4_25degC
XC_A_bot_2u2_0402_3 A_bot_V A_bot_G GRT155C81C225KE13_DC8V4_25degC
XC_A_bot_2u2_0402_4 A_bot_V A_bot_G GRT155C81C225KE13_DC8V4_25degC
XC_B_bot_2u2_0402_0 B_bot_V B_bot_G GRT155C81C225KE13_DC8V4_25degC
XC_B_bot_2u2_0402_1 B_bot_V B_bot_G GRT155C81C225KE13_DC8V4_25degC
XC_B_bot_2u2_0402_2 B_bot_V B_bot_G GRT155C81C225KE13_DC8V4_25degC
XC_B_bot_2u2_0402_3 B_bot_V B_bot_G GRT155C81C225KE13_DC8V4_25degC
XC_B_bot_2u2_0402_4 B_bot_V B_bot_G GRT155C81C225KE13_DC8V4_25degC
XC_C_bot_2u2_0402_0 C_bot_V C_bot_G GRT155C81C225KE13_DC8V4_25degC
XC_C_bot_2u2_0402_1 C_bot_V C_bot_G GRT155C81C225KE13_DC8V4_25degC
XC_C_bot_2u2_0402_2 C_bot_V C_bot_G GRT155C81C225KE13_DC8V4_25degC
XC_C_bot_2u2_0402_3 C_bot_V C_bot_G GRT155C81C225KE13_DC8V4_25degC
XC_C_bot_2u2_0402_4 C_bot_V C_bot_G GRT155C81C225KE13_DC8V4_25degC
XC_A_top_10u_0603_0 A_top_V A_top_G GRT188C81C106ME13_DC8V4_25degC
XC_A_top_10u_0603_1 A_top_V A_top_G GRT188C81C106ME13_DC8V4_25degC
XC_A_top_10u_0603_2 A_top_V A_top_G GRT188C81C106ME13_DC8V4_25degC
XC_A_top_10u_0603_3 A_top_V A_top_G GRT188C81C106ME13_DC8V4_25degC
XC_A_top_10u_0603_4 A_top_V A_top_G GRT188C81C106ME13_DC8V4_25degC
XC_A_top_2u2_0402_0 A_top_V A_top_G GRT155C81C225KE13_DC8V4_25degC
XC_A_top_2u2_0402_1 A_top_V A_top_G GRT155C81C225KE13_DC8V4_25degC
XC_A_top_2u2_0402_2 A_top_V A_top_G GRT155C81C225KE13_DC8V4_25degC
XC_A_top_2u2_0402_3 A_top_V A_top_G GRT155C81C225KE13_DC8V4_25degC
XC_A_top_2u2_0402_4 A_top_V A_top_G GRT155C81C225KE13_DC8V4_25degC
XC_B_top_10u_0603_0 B_top_V B_top_G GRT188C81C106ME13_DC8V4_25degC
XC_B_top_10u_0603_1 B_top_V B_top_G GRT188C81C106ME13_DC8V4_25degC
XC_B_top_10u_0603_2 B_top_V B_top_G GRT188C81C106ME13_DC8V4_25degC
XC_B_top_10u_0603_3 B_top_V B_top_G GRT188C81C106ME13_DC8V4_25degC
XC_B_top_10u_0603_4 B_top_V B_top_G GRT188C81C106ME13_DC8V4_25degC
XC_B_top_2u2_0402_0 B_top_V B_top_G GRT155C81C225KE13_DC8V4_25degC
XC_B_top_2u2_0402_1 B_top_V B_top_G GRT155C81C225KE13_DC8V4_25degC
XC_B_top_2u2_0402_2 B_top_V B_top_G GRT155C81C225KE13_DC8V4_25degC
XC_B_top_2u2_0402_3 B_top_V B_top_G GRT155C81C225KE13_DC8V4_25degC
XC_B_top_2u2_0402_4 B_top_V B_top_G GRT155C81C225KE13_DC8V4_25degC
XC_C_top_10u_0603_0 C_top_V C_top_G GRT188C81C106ME13_DC8V4_25degC
XC_C_top_10u_0603_1 C_top_V C_top_G GRT188C81C106ME13_DC8V4_25degC
XC_C_top_10u_0603_2 C_top_V C_top_G GRT188C81C106ME13_DC8V4_25degC
XC_C_top_10u_0603_3 C_top_V C_top_G GRT188C81C106ME13_DC8V4_25degC
XC_C_top_10u_0603_4 C_top_V C_top_G GRT188C81C106ME13_DC8V4_25degC
XC_C_top_2u2_0402_0 C_top_V C_top_G GRT155C81C225KE13_DC8V4_25degC
XC_C_top_2u2_0402_1 C_top_V C_top_G GRT155C81C225KE13_DC8V4_25degC
XC_C_top_2u2_0402_2 C_top_V C_top_G GRT155C81C225KE13_DC8V4_25degC
XC_C_top_2u2_0402_3 C_top_V C_top_G GRT155C81C225KE13_DC8V4_25degC
XC_C_top_2u2_0402_4 C_top_V C_top_G GRT155C81C225KE13_DC8V4_25degC
XC_BULK_L_47u_1210_0 BULK_L_V BULK_L_G GRT32EC81C476KE13_DC8V4_25degC
XC_BULK_L_47u_1210_1 BULK_L_V BULK_L_G GRT32EC81C476KE13_DC8V4_25degC
XC_BULK_L_47u_1210_2 BULK_L_V BULK_L_G GRT32EC81C476KE13_DC8V4_25degC
XC_BULK_L_47u_1210_3 BULK_L_V BULK_L_G GRT32EC81C476KE13_DC8V4_25degC
XC_BULK_R_47u_1210_0 BULK_R_V BULK_R_G GRT32EC81C476KE13_DC8V4_25degC
XC_BULK_R_47u_1210_1 BULK_R_V BULK_R_G GRT32EC81C476KE13_DC8V4_25degC
XC_BULK_R_47u_1210_2 BULK_R_V BULK_R_G GRT32EC81C476KE13_DC8V4_25degC
XC_BULK_R_47u_1210_3 BULK_R_V BULK_R_G GRT32EC81C476KE13_DC8V4_25degC
VFS FEED_V fe0 0
RFEXT fe0 fe1 0.001
LFEXT fe1 fe2 2.2000e-10
XC_J1_0 fe2 FEED_G GRT32EC81C476KE13_DC8V4_25degC
XC_J1_1 fe2 FEED_G GRT32EC81C476KE13_DC8V4_25degC
RSRC fe2 fs1 0.05
LSRC fs1 fs2 1e-07
VBAT fs2 FEED_G 0
IDEV devC_V 0 AC 1
.ac dec 40 1e4 1e9
.print ac format=csv vr(devC_V) vi(devC_V) vr(P105_V,P105_G) vi(P105_V,P105_G) vr(P110_V,P110_G) vi(P110_V,P110_G) ir(VFS) ii(VFS)
.end
